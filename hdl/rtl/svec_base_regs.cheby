# SPDX-FileCopyrightText: 2022 CERN (home.cern)
#
# SPDX-License-Identifier: CERN-OHL-W-2.0

memory-map:
  name: svec_base_regs
  bus: wb-32-be
  size: 0x4000
  description: SVEC base registers
  children:
    - submap:
        name: metadata
        description: a ROM containing the carrier metadata
        size: 0x40
        interface: sram
    - block:
       name: csr
       description: carrier and fmc status and control
       address: 0x40
       children:
       - reg:
          name: app_offset
          description: offset to the application metadata
          access: ro
          width: 32
       - reg:
          name: resets
          description: global and application resets
          access: rw
          width: 32
          children:
           - field:
              name: global
              range: 0
           - field:
              name: appl
              range: 1
       - reg:
          name: fmc_presence
          description: presence lines for the fmcs
          access: ro
          width: 32
       - reg:
          name: unused0
          description: unused (status of gennum)
          access: ro
          width: 32
          preset: 0
          x-hdl:
            type: const
       - reg:
          name: ddr_status
          description: status of the ddr controllers
          access: ro
          width: 32
          children:
           - field:
               description: Set when ddr4 calibration is done.
               name: ddr4_calib_done
               range: 0
           - field:
               description: Set when ddr5 calibration is done.
               name: ddr5_calib_done
               range: 1
       - reg:
          name: pcb_rev
          description: pcb revision
          access: ro
          width: 32
          children:
           - field:
              name: rev
              description: The PCB revision number
              range: 4-0
       - reg:
          name: ddr4_addr
          description: address of data to read or to write
          access: rw
          width: 32
          x-hdl:
            type: wire
            write-strobe: True
       - reg:
          name: ddr5_addr
          description: address of data to read or to write
          access: rw
          width: 32
          x-hdl:
            type: wire
            write-strobe: True
    - submap:
        name: therm_id
        description: Thermometer and unique id
        address: 0x80
        size: 0x10
        interface: wb-32-be
        x-hdl:
          busgroup: True
    - submap:
        name: fmc_i2c
        description: i2c controllers to the fmcs
        address: 0xa0
        size: 0x20
        interface: wb-32-be
        x-hdl:
          busgroup: True
    - submap:
        name: flash_spi
        description: spi controller to the flash
        address: 0xc0
        size: 0x20
        interface: wb-32-be
        x-hdl:
          busgroup: True
    - submap:
        name: vic
        description: vector interrupt controller
        address: 0x100
        size: 0x100
        interface: wb-32-be
        x-hdl:
          busgroup: True
    - submap:
        name: buildinfo
        description: a ROM containing build information
        address: 0x200
        size: 0x100
        interface: sram
    - submap:
        name: wrc_regs
        address: 0x1000
        description: white-rabbit core registers
        comment: In particular, the vuart is at 0x1500
        size: 0x800
        interface: wb-32-be
        x-hdl:
          busgroup: True
    - submap:
        name: ddr4_data
        description: DMA page for ddr4
        address: 0x2000
        size: 0x1000
        interface: wb-32-be
        x-hdl:
          busgroup: True
    - submap:
        name: ddr5_data
        description: DMA page for ddr5
        address: 0x3000
        size: 0x1000
        interface: wb-32-be
        x-hdl:
          busgroup: True
